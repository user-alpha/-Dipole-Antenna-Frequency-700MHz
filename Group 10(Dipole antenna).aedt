# Ansys Electronics Desktop project, version 2019.3
materials:
  vacuum: permittivity=1
  pec: conductivity=1e+30
  PMLGroup1_Z_1: permittivity{anisotropic component1=1.3898825 component2=1.3898825 component3=0.35974263} permeability{anisotropic component1=1.3898825 component2=1.3898825 component3=0.35974263} dielectric_loss_tangent{anisotropic component1=1 component2=1 component3=-1} magnetic_loss_tangent{anisotropic component1=1 component2=1 component3=-1}
  PMLGroup1_XZ_1: permittivity{anisotropic component1=1 component2=0.01 component3=1} permeability{anisotropic component1=1 component2=0.01 component3=1} dielectric_loss_tangent{anisotropic component1=0 component2=386.35469 component3=0} magnetic_loss_tangent{anisotropic component1=0 component2=386.35469 component3=0}
  PMLGroup1_YZ_1: permittivity{anisotropic component1=0.01 component2=1 component3=1} permeability{anisotropic component1=0.01 component2=1 component3=1} dielectric_loss_tangent{anisotropic component1=386.35469 component2=0 component3=0} magnetic_loss_tangent{anisotropic component1=386.35469 component2=0 component3=0}
  PMLGroup1_XYZ_1: permittivity{anisotropic component1=1.3898825 component2=1.3898825 component3=1.3898825} permeability{anisotropic component1=1.3898825 component2=1.3898825 component3=1.3898825} dielectric_loss_tangent{anisotropic component1=1 component2=1 component3=1} magnetic_loss_tangent{anisotropic component1=1 component2=1 component3=1}

design HFSSDesign2 (HFSS, DrivenModal, model units mm)
variables:
  dR = 1mm
  dL = 150mm
  gL = 1mm
geometry:
  Dipole [pec] = cylinder(axis=Z, base_centre=(0mm, 0mm, -dL/2), radius=dR, height=200mm)
  Gap [vacuum] = cylinder(axis=Z, base_centre=(0mm, 0mm, -gL/2), radius=dR, height=gL)
  Gap_1 = Gap.copy()
  Dipole.subtract(Gap_1)
  Gap_Section1 = Gap.section(plane=YZ)
  RadiatingSurface [vacuum] = region(absolute_offset=75mm on all sides)
  coordinate_system FaceCS1 = face of RadiatingSurface: Origin=RadiatingSurface.vertex(1 of 8) FaceID=RadiatingSurface.face(+z) AxisPosn=RadiatingSurface.vertex(2 of 8) WhichAxis=X ZRotationAngle=0 XOffset=0 YOffset=0
  PML_RadiatingSurface_1 [PMLGroup1_Z_1, oriented by FaceCS1] = sweep_along_normal(RadiatingSurface.face(+z), length=96.513855mm)
  coordinate_system FaceCS2 = face of RadiatingSurface: Origin=RadiatingSurface.vertex(5 of 8) FaceID=RadiatingSurface.face(-z) AxisPosn=RadiatingSurface.vertex(6 of 8) WhichAxis=X ZRotationAngle=0 XOffset=0 YOffset=0
  PML_RadiatingSurface_2 [PMLGroup1_Z_1, oriented by FaceCS2] = sweep_along_normal(RadiatingSurface.face(-z), length=96.513855mm)
  coordinate_system FaceCS3 = face of RadiatingSurface: Origin=RadiatingSurface.vertex(4 of 8) FaceID=RadiatingSurface.face(-y) AxisPosn=RadiatingSurface.vertex(7 of 8) WhichAxis=X ZRotationAngle=0 XOffset=0 YOffset=0
  PML_RadiatingSurface_3 [PMLGroup1_Z_1, oriented by FaceCS3] = sweep_along_normal(RadiatingSurface.face(-y), length=96.513855mm)
  coordinate_system FaceCS4 = face of RadiatingSurface: Origin=RadiatingSurface.vertex(3 of 8) FaceID=RadiatingSurface.face(-x) AxisPosn=RadiatingSurface.vertex(8 of 8) WhichAxis=X ZRotationAngle=0 XOffset=0 YOffset=0
  PML_RadiatingSurface_4 [PMLGroup1_Z_1, oriented by FaceCS4] = sweep_along_normal(RadiatingSurface.face(-x), length=96.513855mm)
  coordinate_system FaceCS5 = face of RadiatingSurface: Origin=RadiatingSurface.vertex(2 of 8) FaceID=RadiatingSurface.face(+y) AxisPosn=RadiatingSurface.vertex(5 of 8) WhichAxis=X ZRotationAngle=0 XOffset=0 YOffset=0
  PML_RadiatingSurface_5 [PMLGroup1_Z_1, oriented by FaceCS5] = sweep_along_normal(RadiatingSurface.face(+y), length=96.513855mm)
  coordinate_system FaceCS6 = face of RadiatingSurface: Origin=RadiatingSurface.vertex(1 of 8) FaceID=RadiatingSurface.face(+x) AxisPosn=RadiatingSurface.vertex(6 of 8) WhichAxis=X ZRotationAngle=0 XOffset=0 YOffset=0
  PML_RadiatingSurface_6 [PMLGroup1_Z_1, oriented by FaceCS6] = sweep_along_normal(RadiatingSurface.face(+x), length=96.513855mm)
  PML_RadiatingSurface_7 [PMLGroup1_XZ_1, oriented by FaceCS3] = sweep_along_normal(PML_RadiatingSurface_1.face(at (0, -76, 248.257)), length=96.513855mm)
  PML_RadiatingSurface_8 [PMLGroup1_XZ_1, oriented by FaceCS4] = sweep_along_normal(PML_RadiatingSurface_1.face(at (-76, 0, 248.257)), length=96.513855mm)
  PML_RadiatingSurface_9 [PMLGroup1_XZ_1, oriented by FaceCS5] = sweep_along_normal(PML_RadiatingSurface_1.face(at (0, 76, 248.257)), length=96.513855mm)
  PML_RadiatingSurface_10 [PMLGroup1_YZ_1, oriented by FaceCS1] = sweep_along_normal(PML_RadiatingSurface_1.face(at (76, 0, 248.257)), length=96.513855mm)
  coordinate_system FaceCS7 = face of RadiatingSurface: Origin=RadiatingSurface.vertex(6 of 8) FaceID=RadiatingSurface.face(-z) AxisPosn=RadiatingSurface.vertex(7 of 8) WhichAxis=X ZRotationAngle=0 XOffset=0 YOffset=0
  PML_RadiatingSurface_11 [PMLGroup1_YZ_1, oriented by FaceCS7] = sweep_along_normal(PML_RadiatingSurface_2.face(at (0, -76, -198.257)), length=96.513855mm)
  coordinate_system FaceCS8 = face of RadiatingSurface: Origin=RadiatingSurface.vertex(7 of 8) FaceID=RadiatingSurface.face(-z) AxisPosn=RadiatingSurface.vertex(8 of 8) WhichAxis=X ZRotationAngle=0 XOffset=0 YOffset=0
  PML_RadiatingSurface_12 [PMLGroup1_YZ_1, oriented by FaceCS8] = sweep_along_normal(PML_RadiatingSurface_2.face(at (-76, 0, -198.257)), length=96.513855mm)
  PML_RadiatingSurface_13 [PMLGroup1_XZ_1, oriented by FaceCS2] = sweep_along_normal(PML_RadiatingSurface_2.face(at (0, 76, -198.257)), length=96.513855mm)
  PML_RadiatingSurface_14 [PMLGroup1_YZ_1, oriented by FaceCS2] = sweep_along_normal(PML_RadiatingSurface_2.face(at (76, 0, -198.257)), length=96.513855mm)
  PML_RadiatingSurface_15 [PMLGroup1_YZ_1, oriented by FaceCS3] = sweep_along_normal(PML_RadiatingSurface_3.face(at (-76, -124.257, 25)), length=96.513855mm)
  PML_RadiatingSurface_16 [PMLGroup1_YZ_1, oriented by FaceCS6] = sweep_along_normal(PML_RadiatingSurface_3.face(at (76, -124.257, 25)), length=96.513855mm)
  PML_RadiatingSurface_17 [PMLGroup1_YZ_1, oriented by FaceCS4] = sweep_along_normal(PML_RadiatingSurface_4.face(at (-124.257, 76, 25)), length=96.513855mm)
  PML_RadiatingSurface_18 [PMLGroup1_YZ_1, oriented by FaceCS5] = sweep_along_normal(PML_RadiatingSurface_5.face(at (76, 124.257, 25)), length=96.513855mm)
  PML_RadiatingSurface_19 [PMLGroup1_XYZ_1, oriented by FaceCS3] = sweep_along_normal(PML_RadiatingSurface_7.face(at (-76, -124.257, 248.257)), length=96.513855mm)
  PML_RadiatingSurface_20 [PMLGroup1_XYZ_1, oriented by FaceCS1] = sweep_along_normal(PML_RadiatingSurface_7.face(at (76, -124.257, 248.257)), length=96.513855mm)
  PML_RadiatingSurface_21 [PMLGroup1_XYZ_1, oriented by FaceCS4] = sweep_along_normal(PML_RadiatingSurface_8.face(at (-124.257, 76, 248.257)), length=96.513855mm)
  PML_RadiatingSurface_22 [PMLGroup1_XYZ_1, oriented by FaceCS5] = sweep_along_normal(PML_RadiatingSurface_9.face(at (76, 124.257, 248.257)), length=96.513855mm)
  PML_RadiatingSurface_23 [PMLGroup1_XYZ_1, oriented by FaceCS8] = sweep_along_normal(PML_RadiatingSurface_11.face(at (-76, -124.257, -198.257)), length=96.513855mm)
  PML_RadiatingSurface_24 [PMLGroup1_XYZ_1, oriented by FaceCS7] = sweep_along_normal(PML_RadiatingSurface_11.face(at (76, -124.257, -198.257)), length=96.513855mm)
  coordinate_system FaceCS9 = face of RadiatingSurface: Origin=RadiatingSurface.vertex(8 of 8) FaceID=RadiatingSurface.face(-z) AxisPosn=RadiatingSurface.vertex(5 of 8) WhichAxis=X ZRotationAngle=0 XOffset=0 YOffset=0
  PML_RadiatingSurface_25 [PMLGroup1_XYZ_1, oriented by FaceCS9] = sweep_along_normal(PML_RadiatingSurface_12.face(at (-124.257, 76, -198.257)), length=96.513855mm)
  PML_RadiatingSurface_26 [PMLGroup1_XYZ_1, oriented by FaceCS2] = sweep_along_normal(PML_RadiatingSurface_13.face(at (76, 124.257, -198.257)), length=96.513855mm)
boundaries and excitations:
  PML_radiation1: Radiation Faces=RadiatingSurface.face(+z) IsForPML
  PML_radiation2: Radiation Faces=RadiatingSurface.face(-z) IsForPML
  PML_radiation3: Radiation Faces=RadiatingSurface.face(-y) IsForPML
  PML_radiation4: Radiation Faces=RadiatingSurface.face(-x) IsForPML
  PML_radiation5: Radiation Faces=RadiatingSurface.face(+y) IsForPML
  PML_radiation6: Radiation Faces=RadiatingSurface.face(+x) IsForPML
  1: Lumped Port Objects=Gap_Section1 Modes{Mode1{IntLine{middle of Gap_Section1.edge(at (0, 0, -0.5)) -> middle of Gap_Section1.edge(at (0, 0, 0.5))} CharImp=Zpi RenormImp=50ohm}} Impedance=50ohm
setups:
  700MHz: HfssDriven Frequency=700MHz MaxDeltaS=0.02 MaximumPasses=20 MinimumPasses=1 MinimumConvergedPasses=1 PercentRefinement=30 BasisOrder=1 PortAccuracy=2
    sweep Sweep: 350MHz to 1500MHz, 401 points; Type=Fast SaveFields SaveRadFields
  700MHz1: HfssDriven Frequency=700MHz MaxDeltaS=0.02 MaximumPasses=20 MinimumPasses=1 MinimumConvergedPasses=1 PercentRefinement=30 BasisOrder=1 PortAccuracy=2
    sweep Sweep: 350MHz to 1500MHz, 101 points; Type=Discrete SaveFields SaveRadFields
source amplitudes:
  1:1: 1W 0deg
radiation setups:
  3D: Infinite Sphere Theta=0deg..360deg step 1deg Phi=-180deg..180deg step 1deg
  Elevation: Infinite Sphere Theta=-180deg..180deg step 1deg Phi=0deg..90deg step 90deg
  Azimuth: Infinite Sphere Theta=90deg..90deg step 0deg Phi=-180deg..180deg step 1deg
reports:
  S Parameter Plot 1: dB(S(1,1)) vs Freq on 700MHz : Sweep; markers m1 at 0.70075GHz
  VSWR Plot 1: dB(VSWR(1)) vs Freq on 700MHz : Sweep; markers m1 at 0.70075GHz
  E - Plane: dB(rETotal) vs Theta on 700MHz : LastAdaptive, 3D [Phi=0deg Freq=0.7GHz]
  H - Plane: dB(GainPhi), dB(GainTheta) vs Phi on 700MHz : LastAdaptive, 3D [Theta=90deg Freq=0.7GHz]
